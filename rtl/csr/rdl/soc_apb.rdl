// Storage_SoC APB register blocks.
//
// This file is the single source for:
//   rtl/csr/gen/*.sv             register RTL         (PeakRDL-regblock, one module per block)
//   fw/common/soc_regs.h         firmware header      (PeakRDL-cheader)
//   dv/ral/soc_apb_ral_pkg.sv    UVM register model   (PeakRDL-uvm)
//   docs/regs/soc_apb.md         register document    (PeakRDL-markdown)
// flow/rdl/gen.sh regenerates all of them; the generated files are committed.
//
// Hardware behavior around the registers (counting, interrupt priority,
// console and exit events) is in rtl/periph/apb_*.sv.

addrmap sys_regs {
  name = "SYS";
  desc = "Identification, a scratch register, and the simulation console and exit registers.";
  default regwidth = 32;
  default accesswidth = 32;

  reg {
    name = "ID";
    desc = "Fixed identification value, \"SSOC\" in ASCII.";
    field { sw = r; hw = na; } value[31:0] = 32'h5353_4F43;
  } ID @ 0x000;

  reg {
    name = "VERSION";
    desc = "Register map version: 0x0003_0002 is the map of step 3-3 (BCH in the NAND channels).";
    field { sw = r; hw = na; } value[31:0] = 32'h0003_0002;
  } VERSION @ 0x004;

  reg {
    name = "SCRATCH";
    desc = "Free for software. Byte strobes are honored.";
    field { sw = rw; hw = na; } value[31:0] = 32'h0;
  } SCRATCH @ 0x008;

  reg {
    name = "CONSOLE";
    desc = "A write sends CHAR to the simulation console. Reads return 0.";
    field { sw = w; hw = r; swmod; } char[7:0] = 8'h0;
  } CONSOLE @ 0x010;

  reg {
    name = "EXIT";
    desc = "A write ends the simulation with CODE; 0 means pass. Reads return 0.";
    field { sw = w; hw = r; swmod; } code[31:0] = 32'h0;
  } EXIT @ 0x014;

  // Control registers start at 0x100; 0x018 to 0x0FC stay undefined.
  reg {
    name = "SOFT_RESET";
    desc = "While a bit is 1 its block is held in reset. Use only while the block is idle: a block reset with transactions outstanding leaves them unanswered.";
    field { sw = rw; hw = r; desc = "DMA, registers included."; } dma[0:0] = 1'b0;
    field { sw = rw; hw = r; desc = "NAND0: both clock domains, registers included (the page buffer keeps its contents)."; } nand0[1:1] = 1'b0;
    field { sw = rw; hw = r; desc = "NAND1, as NAND0."; } nand1[2:2] = 1'b0;
  } SOFT_RESET @ 0x100;

  reg {
    name = "CLK_GATE";
    desc = "Clock gates for idle blocks.";
    field { sw = rw; hw = r; desc = "Gate the CPU's clock while it sleeps in WFI with no interrupt pending, as Ibex's own top level does."; } cpu[0:0] = 1'b1;
  } CLK_GATE @ 0x104;

  reg {
    name = "SLEEP_CYCLES";
    desc = "Clocks the CPU's clock gate has removed since reset.";
    field { sw = r; hw = w; } count[31:0];
  } SLEEP_CYCLES @ 0x108;
};

addrmap pmu_regs {
  name = "PMU";
  desc = "Power management in PD_AON, clocked by clk_aon and reset only at power-on; reached through an APB clock-domain crossing (rtl/pmu/apb_cdc.sv), so an access takes a few clk_aon cycles. Sequences and states are in docs/07_clock_reset_power.md.";
  default regwidth = 32;
  default accesswidth = 32;

  reg {
    name = "PWR_CTRL";
    desc = "UP starts the PD_HOST power-up sequence from OFF or FAIL; DOWN starts the power-down sequence from ON. Both read as 0.";
    field { sw = w; hw = r; singlepulse; } up[0:0] = 1'b0;
    field { sw = w; hw = r; singlepulse; } down[1:1] = 1'b0;
    field { sw = rw; hw = r; desc = "A rising edge on the wake pin powers PD_HOST up from OFF."; } wake_en[8:8] = 1'b1;
  } PWR_CTRL @ 0x000;

  reg {
    name = "PWR_STATUS";
    field { sw = r; hw = w; desc = "Sequencer state: 0 OFF, 1-4 powering up, 5 ON, 6-10 powering down, 11 FAIL."; } state[3:0];
    field { sw = r; hw = w; desc = "PD_HOST is on with isolation released."; } on[8:8];
    field { sw = r; hw = w; desc = "Last sequence: 0 none, 1 completed, 2 power-down refused (host path busy), 3 timeout."; } result[17:16];
    field { sw = r; hw = w; desc = "The last power-up was started by the wake pin."; } woke[24:24];
  } PWR_STATUS @ 0x004;

  reg {
    name = "PWR_IRQ";
    desc = "INTC source 10. Write 1 to clear. A hardware set wins over a software clear in the same clock.";
    field { sw = rw; onwrite = woclr; hw = r; hwset; precedence = hw; desc = "A sequence completed."; } done[0:0] = 1'b0;
    field { sw = rw; onwrite = woclr; hw = r; hwset; precedence = hw; desc = "A power-down was refused or a sequence timed out."; } err[1:1] = 1'b0;
  } PWR_IRQ @ 0x008;

  reg {
    name = "TIMEOUT";
    desc = "clk_aon cycles each wait of a sequence may take (switch acknowledge, PLL lock).";
    field { sw = rw; hw = r; } cycles[15:0] = 16'd64;
  } TIMEOUT @ 0x00C;

  reg {
    name = "CHIP_RESET";
    desc = "Writing 0x5AFE_0001 resets PD_CORE and PD_HOST's logic and runs the reset release order again; PD_AON and PD_HOST's power state are kept. Any other value is ignored. Reads return 0.";
    field { sw = w; hw = r; swmod; } key[31:0] = 32'h0;
  } CHIP_RESET @ 0x010;

  reg {
    name = "RST_CAUSE";
    desc = "Why PD_CORE was last reset. Write 1 to clear.";
    field { sw = rw; onwrite = woclr; hw = r; hwset; precedence = hw; desc = "Power-on reset."; } por[0:0] = 1'b0;
    field { sw = rw; onwrite = woclr; hw = r; hwset; precedence = hw; desc = "CHIP_RESET."; } chip[1:1] = 1'b0;
  } RST_CAUSE @ 0x014;

  reg {
    name = "AON_SCRATCH";
    desc = "Free for software; kept across a chip reset.";
    field { sw = rw; hw = na; } value[31:0] = 32'h0;
  } AON_SCRATCH @ 0x018;

  reg {
    name = "PWR_CYCLES";
    desc = "Completed PD_HOST power-downs since power-on.";
    field { sw = r; hw = w; } count[15:0];
  } PWR_CYCLES @ 0x01C;
};

addrmap host_regs {
  name = "HOST";
  desc = "Host interface (rtl/host/): the transaction layer's windows, bus master, MSI-X requests, link hold and error status (docs/10_transaction_layer.md), and the PD_HOST placeholder's command and response FIFOs at 0x000 to 0x008, kept for the power tests until the link layer arrives in step 2-6.";
  default regwidth = 32;
  default accesswidth = 32;

  reg {
    name = "TX";
    desc = "A write sends one command into PD_HOST. It is dropped, and STATUS.TX_DROP set, when the FIFO is full or PD_HOST is not on.";
    field { sw = w; hw = r; swmod; } data[31:0] = 32'h0;
  } TX @ 0x000;

  reg {
    name = "RX";
    desc = "Oldest response; reading it removes it. Reads 0 when STATUS.RX_VALID is 0.";
    field { sw = r; hw = w; swacc; } data[31:0];
  } RX @ 0x004;

  reg {
    name = "STATUS";
    field { sw = r; hw = w; desc = "A response is waiting in RX."; } rx_valid[0:0];
    field { sw = r; hw = w; desc = "The command FIFO is full."; } tx_full[1:1];
    field { sw = r; hw = w; desc = "PD_HOST is on (PMU)."; } on[2:2];
    field { sw = r; hw = w; desc = "Every command sent has had its response read: the host path is idle."; } idle[3:3];
    field { sw = rw; onwrite = woclr; hw = r; hwset; precedence = hw; desc = "A command was dropped."; } tx_drop[8:8] = 1'b0;
  } STATUS @ 0x008;

  reg {
    name = "LINK_CTRL";
    field { sw = rw; hw = r; desc = "Hold: the link side stops taking new TLPs from the host at the next TLP boundary. Set it before a PD_HOST power-down (the PMU refuses one while the host path is not held and idle) and clear it after the power-up."; } hold[0:0] = 1'b0;
  } LINK_CTRL @ 0x010;

  reg {
    name = "LINK_STATUS";
    desc = "Transaction layer state and the configuration-space settings the host has made.";
    field { sw = r; hw = w; desc = "Hold is in effect: no TLP from the host is in progress."; } hold_ack[0:0];
    field { sw = r; hw = w; desc = "The host path is held and idle, as the PMU sees it."; } idle[1:1];
    field { sw = r; hw = w; desc = "Memory Space Enable."; } mse[2:2];
    field { sw = r; hw = w; desc = "Bus Master Enable."; } bme[3:3];
    field { sw = r; hw = w; desc = "MSI-X Enable."; } msix_en[4:4];
    field { sw = r; hw = w; desc = "MSI-X Function Mask."; } msix_fmask[5:5];
    field { sw = r; hw = w; desc = "Max_Payload_Size is 256 bytes (else 128)."; } mps256[6:6];
    field { sw = r; hw = w; desc = "Max_Read_Request_Size code: 128 << MRRS bytes."; } mrrs[10:8];
    field { sw = r; hw = w; desc = "Bus and device number captured from configuration writes; function 0."; } id[31:16];
  } LINK_STATUS @ 0x014;

  reg {
    name = "BAR2_WIN";
    desc = "AXI address of BAR2 (32 KiB aligned). Reset value: the upper half of SRAM.";
    field { sw = rw; hw = r; } base[31:15] = 17'h0_2001;
  } BAR2_WIN @ 0x01C;

  reg {
    name = "BM_HADDR_LO";
    desc = "Bus master: host address, bits 31:2. Host address, local address and length are DW-granular.";
    field { sw = rw; hw = r; } addr[31:2] = 30'h0;
  } BM_HADDR_LO @ 0x020;

  reg {
    name = "BM_HADDR_HI";
    field { sw = rw; hw = r; desc = "Bus master: host address, bits 63:32."; } addr[31:0] = 32'h0;
  } BM_HADDR_HI @ 0x024;

  reg {
    name = "BM_LADDR";
    field { sw = rw; hw = r; desc = "Bus master: local (AXI) address, bits 31:2."; } addr[31:2] = 30'h0;
  } BM_LADDR @ 0x028;

  reg {
    name = "BM_LEN";
    field { sw = rw; hw = r; desc = "Bus master: length in bytes, a multiple of 4, 4 to 1 MiB - 4."; } bytes[19:2] = 18'h0;
  } BM_LEN @ 0x02C;

  reg {
    name = "BM_CTRL";
    desc = "START while BM_STATUS.BUSY is ignored.";
    field { sw = w; hw = r; singlepulse; desc = "Start the transfer."; } start[0:0] = 1'b0;
    field { sw = rw; hw = r; desc = "Direction: 1 SoC to host (memory writes), 0 host to SoC (memory reads)."; } d2h[1:1] = 1'b0;
  } BM_CTRL @ 0x030;

  reg {
    name = "BM_STATUS";
    desc = "DONE or ERR is INTC source 12. Write 1 to clear; START clears both.";
    field { sw = r; hw = w; desc = "A transfer is running."; } busy[0:0];
    field { sw = rw; onwrite = woclr; hw = r; hwset; hwclr; precedence = hw; desc = "The transfer ended without an error."; } done[1:1] = 1'b0;
    field { sw = rw; onwrite = woclr; hw = r; hwset; hwclr; precedence = hw; desc = "The transfer ended with an error; see CAUSE."; } err[2:2] = 1'b0;
    field { sw = r; hw = w; we; desc = "Cause of the last error: 1 Bus Master Enable clear, 2 local AXI error, 3 UR completion, 4 CA completion, 5 completion timeout, 6 bad or poisoned completion."; } cause[6:4] = 3'h0;
  } BM_STATUS @ 0x034;

  reg {
    name = "BM_CYCLES";
    desc = "Clocks from START to the end of the last transfer.";
    field { sw = r; hw = w; } count[31:0];
  } BM_CYCLES @ 0x038;

  reg {
    name = "MSIX_REQ";
    desc = "A write requests the MSI-X vector it names. While MSI-X is disabled the request is dropped (ERR_STATUS.MSIX_DROP).";
    field { sw = w; hw = r; swmod; } vector[2:0] = 3'h0;
  } MSIX_REQ @ 0x03C;

  reg {
    name = "MSIX_PEND";
    field { sw = r; hw = w; desc = "Pending Bit Array: vectors requested while masked."; } pending[7:0];
  } MSIX_PEND @ 0x040;

  reg {
    name = "CPL_TIMEOUT";
    field { sw = rw; hw = r; desc = "Bus master completion timeout in units of 64 clocks (reset: 4096 clocks). Device Control 2 can disable it."; } ticks[7:0] = 8'd64;
  } CPL_TIMEOUT @ 0x044;

  reg {
    name = "ERR_STATUS";
    desc = "Transaction layer errors, set by hardware and cleared by writing 1. Bits 0 to 6 together are INTC source 5.";
    field { sw = rw; onwrite = woclr; hw = r; hwset; precedence = hw; desc = "An unsupported request was received."; } ur[0:0] = 1'b0;
    field { sw = rw; onwrite = woclr; hw = r; hwset; precedence = hw; desc = "A malformed TLP was received and dropped."; } malformed[1:1] = 1'b0;
    field { sw = rw; onwrite = woclr; hw = r; hwset; precedence = hw; desc = "A poisoned TLP was received."; } poisoned[2:2] = 1'b0;
    field { sw = rw; onwrite = woclr; hw = r; hwset; precedence = hw; desc = "A completion matched no outstanding request."; } unexp_cpl[3:3] = 1'b0;
    field { sw = rw; onwrite = woclr; hw = r; hwset; precedence = hw; desc = "A bus master request timed out."; } cpl_timeout[4:4] = 1'b0;
    field { sw = rw; onwrite = woclr; hw = r; hwset; precedence = hw; desc = "A UR or CA completion, or one that failed the checks, was received."; } cpl_err[5:5] = 1'b0;
    field { sw = rw; onwrite = woclr; hw = r; hwset; precedence = hw; desc = "An inbound write or read got an AXI error."; } axi_err[6:6] = 1'b0;
    field { sw = rw; onwrite = woclr; hw = r; hwset; precedence = hw; desc = "The link layer discarded a TLP (from step 2-6)."; } discard[7:7] = 1'b0;
    field { sw = rw; onwrite = woclr; hw = r; hwset; precedence = hw; desc = "An MSI-X request was dropped (MSI-X disabled)."; } msix_drop[8:8] = 1'b0;
  } ERR_STATUS @ 0x048;

  reg {
    name = "RX_TLPS";
    desc = "TLPs received and dispatched since reset (wraps).";
    field { sw = r; hw = w; } count[31:0];
  } RX_TLPS @ 0x050;

  reg {
    name = "TX_TLPS";
    desc = "TLPs sent since reset (wraps).";
    field { sw = r; hw = w; } count[31:0];
  } TX_TLPS @ 0x054;
};

addrmap intc_regs {
  name = "INTC";
  desc = "Interrupt controller for level sources 1 to 31. Source IDs are in docs/01, section 7.";
  default regwidth = 32;
  default accesswidth = 32;

  reg {
    name = "PENDING";
    desc = "Sources that are high, OR SWSET. Bit 0 is always 0.";
    field { sw = r; hw = w; } value[31:0];
  } PENDING @ 0x000;

  reg {
    name = "ENABLE";
    desc = "A source raises the core's external interrupt only while its bit is set.";
    field { sw = rw; hw = r; } value[31:0] = 32'h0;
  } ENABLE @ 0x004;

  reg {
    name = "CLAIM";
    desc = "Lowest ID that is pending and enabled, 0 if none. Reading has no side effect.";
    field { sw = r; hw = w; } id[4:0];
  } CLAIM @ 0x008;

  reg {
    name = "SWSET";
    desc = "Software-set sources, ORed into PENDING.";
    field { sw = rw; hw = r; } value[31:0] = 32'h0;
  } SWSET @ 0x00C;
};

addrmap timer_regs {
  name = "TIMER";
  desc = "RISC-V machine timer. The interrupt is high while MTIME >= MTIMECMP.";
  default regwidth = 32;
  default accesswidth = 32;

  reg {
    name = "MTIME_LO";
    desc = "mtime[31:0]. Counts while CTRL.ENABLE is set; a software write takes precedence.";
    field { sw = rw; hw = rw; we; } value[31:0] = 32'h0;
  } MTIME_LO @ 0x000;

  reg {
    name = "MTIME_HI";
    desc = "mtime[63:32].";
    field { sw = rw; hw = rw; we; } value[31:0] = 32'h0;
  } MTIME_HI @ 0x004;

  reg {
    name = "MTIMECMP_LO";
    desc = "mtimecmp[31:0].";
    field { sw = rw; hw = r; } value[31:0] = 32'hFFFF_FFFF;
  } MTIMECMP_LO @ 0x008;

  reg {
    name = "MTIMECMP_HI";
    desc = "mtimecmp[63:32]. Write 0xFFFF_FFFF here first when changing MTIMECMP.";
    field { sw = rw; hw = r; } value[31:0] = 32'hFFFF_FFFF;
  } MTIMECMP_HI @ 0x00C;

  reg {
    name = "CTRL";
    field { sw = rw; hw = r; desc = "Count enable."; } enable[0:0] = 1'b1;
    field { sw = rw; hw = r; desc = "MTIME advances every PRESCALE + 1 clocks."; } prescale[15:8] = 8'h0;
  } CTRL @ 0x010;
};

addrmap dma_regs {
  name = "DMA";
  desc = "Descriptor-based DMA (rtl/dma/dma.sv). Descriptor format and error causes are in docs/06_dma.md.";
  default regwidth = 32;
  default accesswidth = 32;

  reg {
    name = "CTRL";
    desc = "Write 1 to START to run the chain at DESC_PTR, or to ABORT to stop a running chain. Both read as 0. START while BUSY is ignored.";
    field { sw = w; hw = r; singlepulse; desc = "Start the chain at DESC_PTR."; } start[0:0] = 1'b0;
    field { sw = w; hw = r; singlepulse; desc = "Stop after the transactions already issued complete."; } abort[1:1] = 1'b0;
  } CTRL @ 0x000;

  reg {
    name = "DESC_PTR";
    desc = "Address of the first descriptor; 16-byte aligned.";
    field { sw = rw; hw = r; } addr[31:0] = 32'h0;
  } DESC_PTR @ 0x004;

  reg {
    name = "STATUS";
    desc = "DONE and ERR are the DMA's two interrupt sources (INTC 1 and 2). Write 1 to clear; START clears both. A hardware set wins over a software clear in the same clock, so no event is lost.";
    field { sw = r; hw = w; desc = "A chain is running."; } busy[0:0];
    field { sw = rw; onwrite = woclr; hw = r; hwset; hwclr; precedence = hw; desc = "The chain completed."; } done[1:1] = 1'b0;
    field { sw = rw; onwrite = woclr; hw = r; hwset; hwclr; precedence = hw; desc = "The chain stopped on an error or an abort; see ERR_INFO."; } err[2:2] = 1'b0;
  } STATUS @ 0x008;

  reg {
    name = "ERR_INFO";
    desc = "Why the last run stopped. Cleared by START.";
    field { sw = r; hw = w; we; desc = "1 descriptor read error, 2 data read error, 3 data write error, 4 bad descriptor or DESC_PTR, 5 aborted."; } cause[2:0] = 3'h0;
    field { sw = r; hw = w; we; desc = "RRESP or BRESP of the failed transaction (causes 1 to 3)."; } resp[5:4] = 2'h0;
  } ERR_INFO @ 0x00C;

  reg {
    name = "ERR_ADDR";
    desc = "Causes 1 and 4: the descriptor's address. Causes 2 and 3: the start address of the failed burst. Cause 5: CUR_DESC.";
    field { sw = r; hw = w; we; } addr[31:0] = 32'h0;
  } ERR_ADDR @ 0x010;

  reg {
    name = "CUR_DESC";
    desc = "Address of the descriptor whose data is being read, or was read last.";
    field { sw = r; hw = w; } addr[31:0];
  } CUR_DESC @ 0x014;

  reg {
    name = "DESC_DONE";
    desc = "Descriptors whose writes all completed in this run, counted until the first error.";
    field { sw = r; hw = w; } count[15:0];
  } DESC_DONE @ 0x018;

  reg {
    name = "CYCLES";
    desc = "Clocks from START to the end of the run (counting while BUSY).";
    field { sw = r; hw = w; } count[31:0];
  } CYCLES @ 0x01C;
};

addrmap nvme_regs {
  name = "NVME";
  desc = "Firmware side of the NVMe controller (rtl/host/nvme/nvme_ctrl.sv, docs/11_nvme_queues.md, docs/12_nvme_data.md, docs/14_nvme_host_verification.md). The host side (CAP, CC, CSTS, AQA, ASQ, ACQ, doorbells) is in BAR0 and is mirrored here read-only. The epoch counts controller resets: CMD gives the epoch a command was fetched in, and a transfer start (XF_CTRL), a completion post (CQE_CTRL) or an I/O queue enable (SQ_CFG, CQ_CFG) carrying another epoch does nothing.";
  default regwidth = 32;
  default accesswidth = 32;

  reg {
    name = "CTRL";
    field { sw = rw; hw = r; desc = "Interrupt (INTC source 3) while commands wait in CMD."; } ien_cmd[0:0] = 1'b0;
    field { sw = rw; hw = r; desc = "Interrupt (INTC source 3) while XF_STATUS.DONE or ERR is set."; } ien_xfer[1:1] = 1'b0;
  } CTRL @ 0x000;

  reg {
    name = "STATUS";
    field { sw = r; hw = w; desc = "CSTS.RDY."; } rdy[0:0];
    field { sw = r; hw = w; desc = "CSTS.CFS: a command fetch failed."; } cfs[1:1];
    field { sw = r; hw = w; desc = "CC.EN."; } en[2:2];
    field { sw = r; hw = w; desc = "CSTS.SHST."; } shst[5:4];
    field { sw = r; hw = w; desc = "Commands waiting in CMD."; } cmds[12:8];
    field { sw = r; hw = w; desc = "Free command buffer slots."; } free[20:16];
    field { sw = r; hw = w; desc = "Epoch: controller resets since power-on, modulo 16."; } epoch[27:24];
  } STATUS @ 0x004;

  reg {
    name = "EVENT";
    desc = "Controller events, set by hardware and cleared by writing 1. EVENT AND EVENT_EN is INTC source 3, with CTRL.IEN_CMD.";
    field { sw = rw; onwrite = woclr; hw = r; hwset; precedence = hw; desc = "The host enabled the controller (CC.EN 0 to 1); the admin queue is loaded and CSTS.RDY is 1."; } enable[0:0] = 1'b0;
    field { sw = rw; onwrite = woclr; hw = r; hwset; precedence = hw; desc = "A controller reset (CC.EN 1 to 0) finished: queues deleted, commands dropped, CSTS.RDY 0."; } reset[1:1] = 1'b0;
    field { sw = rw; onwrite = woclr; hw = r; hwset; precedence = hw; desc = "The host requested a shutdown (CC.SHN)."; } shutdown[2:2] = 1'b0;
    field { sw = rw; onwrite = woclr; hw = r; hwset; precedence = hw; desc = "A doorbell write was ignored; see DB_ERR."; } db_err[3:3] = 1'b0;
    field { sw = rw; onwrite = woclr; hw = r; hwset; precedence = hw; desc = "A command fetch failed; CSTS.CFS is set."; } fetch_err[4:4] = 1'b0;
    field { sw = rw; onwrite = woclr; hw = r; hwset; precedence = hw; desc = "A completion queue entry was dropped (posted while 4 wait, or to a completion queue that is not enabled) or its write to the host failed (CSTS.CFS is set); see CQE_STATUS."; } cqe_err[5:5] = 1'b0;
  } EVENT @ 0x008;

  reg {
    name = "EVENT_EN";
    field { sw = rw; hw = r; } en[5:0] = 6'h0;
  } EVENT_EN @ 0x00C;

  reg {
    name = "CC";
    desc = "The host's Controller Configuration.";
    field { sw = r; hw = w; } value[31:0];
  } CC @ 0x010;

  reg {
    name = "CMDBUF";
    desc = "SRAM address of the command buffer: 16 slots of 64 bytes, 1 KiB aligned.";
    field { sw = rw; hw = r; } base[31:10] = 22'h4_002F;
  } CMDBUF @ 0x014;

  reg {
    name = "CMD";
    desc = "Oldest fetched command; reading it removes it. VALID 0 when none waits. The command is at CMDBUF + 64 x SLOT until SLOT_FREE returns the slot.";
    field { sw = r; hw = w; swacc; } slot[3:0];
    field { sw = r; hw = w; desc = "Submission queue it came from."; } sqid[18:16];
    field { sw = r; hw = w; desc = "Epoch it was fetched in; firmware writes it back with the command's transfer and completion."; } epoch[27:24];
    field { sw = r; hw = w; } valid[31:31];
  } CMD @ 0x018;

  reg {
    name = "SLOT_FREE";
    desc = "A write returns the slot it names to the free list, if EPOCH is the controller's and the controller is on (a controller reset has freed every slot already).";
    field { sw = w; hw = r; swmod; } slot[3:0] = 4'h0;
    field { sw = w; hw = r; desc = "The command's epoch (CMD.EPOCH)."; } epoch[7:4] = 4'h0;
  } SLOT_FREE @ 0x01C;

  reg {
    name = "DB_ERR";
    desc = "The last doorbell write that was ignored: to a queue that is not enabled, or a value not below the queue size.";
    field { sw = r; hw = w; we; desc = "Queue ID."; } qid[2:0] = 3'h0;
    field { sw = r; hw = w; we; desc = "1: completion queue head doorbell; 0: submission queue tail doorbell."; } cq[3:3] = 1'b0;
    field { sw = r; hw = w; we; desc = "Value written."; } value[31:16] = 16'h0;
  } DB_ERR @ 0x020;

  reg {
    name = "FETCHES";
    desc = "Commands fetched since reset (wraps).";
    field { sw = r; hw = w; } count[31:0];
  } FETCHES @ 0x024;

  reg {
    name = "AQA";
    field { sw = r; hw = w; desc = "The host's Admin Queue Attributes."; } value[31:0];
  } AQA @ 0x030;

  reg {
    name = "ASQ_LO";
    field { sw = r; hw = w; desc = "Admin Submission Queue base, bits 31:0."; } value[31:0];
  } ASQ_LO @ 0x034;

  reg {
    name = "ASQ_HI";
    field { sw = r; hw = w; } value[31:0];
  } ASQ_HI @ 0x038;

  reg {
    name = "ACQ_LO";
    field { sw = r; hw = w; desc = "Admin Completion Queue base, bits 31:0."; } value[31:0];
  } ACQ_LO @ 0x03C;

  reg {
    name = "ACQ_HI";
    field { sw = r; hw = w; } value[31:0];
  } ACQ_HI @ 0x040;

  // Data transfer between host memory and SRAM by PRP (step 2-3): one at a
  // time; the registers are taken at START.
  reg {
    name = "XF_PRP1_LO";
    field { sw = rw; hw = r; desc = "PRP entry 1, bits 31:0: the first page and the offset in it, DW aligned."; } value[31:0] = 32'h0;
  } XF_PRP1_LO @ 0x050;

  reg {
    name = "XF_PRP1_HI";
    field { sw = rw; hw = r; } value[31:0] = 32'h0;
  } XF_PRP1_HI @ 0x054;

  reg {
    name = "XF_PRP2_LO";
    field { sw = rw; hw = r; desc = "PRP entry 2, bits 31:0: the second page (page aligned) when the data spans two pages, or a PRP list pointer (8-byte aligned) when it spans more."; } value[31:0] = 32'h0;
  } XF_PRP2_LO @ 0x058;

  reg {
    name = "XF_PRP2_HI";
    field { sw = rw; hw = r; } value[31:0] = 32'h0;
  } XF_PRP2_HI @ 0x05C;

  reg {
    name = "XF_LADDR";
    field { sw = rw; hw = r; desc = "SRAM address of the data, contiguous there."; } addr[31:2] = 30'h0;
  } XF_LADDR @ 0x060;

  reg {
    name = "XF_LEN";
    field { sw = rw; hw = r; desc = "Length in bytes, a multiple of 4, 4 to 128 KiB."; } bytes[17:2] = 16'h0;
  } XF_LEN @ 0x064;

  reg {
    name = "XF_CTRL";
    desc = "START while XF_STATUS.BUSY is ignored.";
    field { sw = w; hw = r; singlepulse; desc = "Start the transfer."; } start[0:0] = 1'b0;
    field { sw = rw; hw = r; desc = "1: SRAM to host (a read command); 0: host to SRAM (a write command)."; } d2h[1:1] = 1'b0;
    field { sw = rw; hw = r; desc = "The command's epoch (CMD.EPOCH). A START with another epoch, or while the controller is not on, moves nothing and ends with ERR, cause 11."; } epoch[7:4] = 4'h0;
  } XF_CTRL @ 0x068;

  reg {
    name = "XF_STATUS";
    desc = "DONE or ERR is INTC source 3 with CTRL.IEN_XFER. Write 1 to clear; START clears both.";
    field { sw = r; hw = w; } busy[0:0];
    field { sw = rw; onwrite = woclr; hw = r; hwset; hwclr; precedence = hw; } done[1:1] = 1'b0;
    field { sw = rw; onwrite = woclr; hw = r; hwset; hwclr; precedence = hw; } err[2:2] = 1'b0;
    field { sw = r; hw = w; we; desc = "Why the transfer failed: 1 to 7 the bus master's cause, 8 a length out of range, 9 a PRP entry with a bad offset, 10 aborted by a controller reset, 11 not started: stale epoch or controller not on."; } cause[11:8] = 4'h0;
  } XF_STATUS @ 0x06C;

  reg {
    name = "XF_CYCLES";
    desc = "Clocks from START to the end of the last transfer.";
    field { sw = r; hw = w; } count[31:0];
  } XF_CYCLES @ 0x070;

  // Completion queue entries (step 2-3): writing CQE_CTRL queues an entry
  // built from CQE_DW0, CQE_INFO and CQE_CTRL; up to 4 wait.
  reg {
    name = "CQE_DW0";
    field { sw = rw; hw = r; desc = "Command specific DW0 of the entry."; } value[31:0] = 32'h0;
  } CQE_DW0 @ 0x080;

  reg {
    name = "CQE_INFO";
    field { sw = rw; hw = r; desc = "Command identifier."; } cid[15:0] = 16'h0;
    field { sw = rw; hw = r; desc = "Submission queue the command came from; the entry carries its head."; } sqid[18:16] = 3'h0;
  } CQE_INFO @ 0x084;

  reg {
    name = "CQE_CTRL";
    desc = "A write queues the entry.";
    field { sw = rw; hw = r; swmod; desc = "Completion queue, 0 to 4."; } cqid[2:0] = 3'h0;
    field { sw = rw; hw = r; desc = "The command's epoch (CMD.EPOCH). A post with another epoch, or while the controller is not on, is discarded (CQE_STATUS.STALE)."; } epoch[7:4] = 4'h0;
    field { sw = rw; hw = r; desc = "Status field of DW3 (bits 31:17: SC, SCT, CRD, M, DNR); 0 for success."; } status[31:17] = 15'h0;
  } CQE_CTRL @ 0x088;

  reg {
    name = "CQE_STATUS";
    field { sw = r; hw = w; desc = "Entries waiting to be written."; } count[2:0];
    field { sw = r; hw = w; desc = "4 entries wait: a post now is dropped."; } full[4:4];
    field { sw = r; hw = w; desc = "The oldest entry waits for room in its completion queue."; } cq_full[5:5];
    field { sw = rw; onwrite = woclr; hw = r; hwset; precedence = hw; desc = "An entry was dropped: posted while 4 waited, or to a completion queue that is not enabled."; } drop[8:8] = 1'b0;
    field { sw = rw; onwrite = woclr; hw = r; hwset; precedence = hw; desc = "An entry's write to the host failed."; } werr[9:9] = 1'b0;
    field { sw = rw; onwrite = woclr; hw = r; hwset; precedence = hw; desc = "A post was discarded: its epoch was not the controller's, or the controller was not on. Not an error: the command was dropped by a controller reset."; } stale[10:10] = 1'b0;
  } CQE_STATUS @ 0x08C;

  reg {
    name = "CQES";
    desc = "Completion queue entries written since reset (wraps).";
    field { sw = r; hw = w; } count[31:0];
  } CQES @ 0x090;

  reg {
    name = "STALE";
    desc = "Firmware actions refused for a stale epoch or with the controller not on, since power-on (each count wraps).";
    field { sw = r; hw = w; desc = "Completion posts discarded."; } cqe[15:0];
    field { sw = r; hw = w; desc = "Transfer starts refused."; } xf[31:16];
  } STALE @ 0x094;

  // I/O queue pairs 1 to 4, written by firmware when it handles the admin
  // commands that create and delete them. A controller reset clears EN.
  regfile {
    reg {
      name = "SQB_LO";
      field { sw = rw; hw = r; desc = "Submission queue base, bits 31:12."; } base[31:12] = 20'h0;
    } SQB_LO @ 0x00;
    reg {
      name = "SQB_HI";
      field { sw = rw; hw = r; } base[31:0] = 32'h0;
    } SQB_HI @ 0x04;
    reg {
      name = "SQ_CFG";
      field { sw = rw; hw = r; desc = "Entries - 1."; } size[11:0] = 12'h0;
      field { sw = rw; hw = r; desc = "Completion queue for this submission queue."; } cqid[18:16] = 3'h0;
      field { sw = rw; hw = r; desc = "Epoch of the command that created the queue; the queue is enabled only while it is the controller's."; } epoch[29:26] = 4'h0;
      field { sw = rw; hw = r; hwclr; desc = "Queue enabled; enabling sets its head and tail to 0."; } en[31:31] = 1'b0;
    } SQ_CFG @ 0x08;
    reg {
      name = "CQB_LO";
      field { sw = rw; hw = r; desc = "Completion queue base, bits 31:12."; } base[31:12] = 20'h0;
    } CQB_LO @ 0x0C;
    reg {
      name = "CQB_HI";
      field { sw = rw; hw = r; } base[31:0] = 32'h0;
    } CQB_HI @ 0x10;
    reg {
      name = "CQ_CFG";
      field { sw = rw; hw = r; desc = "Entries - 1."; } size[11:0] = 12'h0;
      field { sw = rw; hw = r; desc = "MSI-X vector."; } iv[18:16] = 3'h0;
      field { sw = rw; hw = r; desc = "Interrupts enabled."; } ien[24:24] = 1'b0;
      field { sw = rw; hw = r; desc = "Epoch of the command that created the queue; the queue is enabled only while it is the controller's."; } epoch[29:26] = 4'h0;
      field { sw = rw; hw = r; hwclr; desc = "Queue enabled; enabling sets head and tail to 0 and the phase to 1."; } en[31:31] = 1'b0;
    } CQ_CFG @ 0x14;
  } IOQ[4] @ 0x100 += 0x20;

  reg {
    name = "SQ_PTR";
    desc = "Submission queue 0 to 4: head (next entry to fetch) and tail (last doorbell).";
    field { sw = r; hw = w; } head[11:0];
    field { sw = r; hw = w; } tail[27:16];
  } SQ_PTR[5] @ 0x200 += 0x4;

  reg {
    name = "CQ_PTR";
    desc = "Completion queue 0 to 4: head (last doorbell), tail (next entry to write) and phase.";
    field { sw = r; hw = w; } head[11:0];
    field { sw = r; hw = w; } tail[27:16];
    field { sw = r; hw = w; } phase[31:31];
  } CQ_PTR[5] @ 0x220 += 0x4;
};

addrmap nand_regs {
  name = "NAND";
  desc = "One NAND channel (rtl/nand/nand_ctrl.sv, docs/15_nand_channel.md): an 8-bit ONFI-style asynchronous interface run by a sequencer in clk_nand, a command queue of 4, a completion queue of 8, and an 8 KiB page buffer on the crossbar. NAND0 is at 0x4000_6000 with its page buffer at 0x3000_0000, NAND1 at 0x4000_7000 and 0x3001_0000.";
  default regwidth = 32;
  default accesswidth = 32;

  reg {
    name = "CTRL";
    field { sw = rw; hw = r; desc = "Write protect: WP# is low while this is 1, from reset until firmware clears it."; } wp[0:0] = 1'b1;
    field { sw = rw; hw = r; desc = "Interrupt (INTC 6 for NAND0, 8 for NAND1) while a completion waits in CPL."; } ien_done[1:1] = 1'b0;
    field { sw = rw; hw = r; desc = "Interrupt (INTC 7 for NAND0, 9 for NAND1) while EVENT.ERR or EVENT.OVF is set."; } ien_err[2:2] = 1'b0;
  } CTRL @ 0x000;

  reg {
    name = "STATUS";
    field { sw = r; hw = w; desc = "A command is running."; } busy[0:0];
    field { sw = r; hw = w; desc = "R/B#, synchronized into clk_sys: 1 ready, 0 busy."; } rb[1:1];
    field { sw = r; hw = w; desc = "Commands waiting in the queue, 0 to 4."; } cmds[10:8];
    field { sw = r; hw = w; desc = "Completions waiting in CPL, 0 to 8."; } cpls[15:12];
  } STATUS @ 0x004;

  reg {
    name = "EVENT";
    desc = "Set by hardware, cleared by writing 1.";
    field { sw = rw; onwrite = woclr; hw = r; hwset; precedence = hw; desc = "A command completed with a code other than 0."; } err[0:0] = 1'b0;
    field { sw = rw; onwrite = woclr; hw = r; hwset; precedence = hw; desc = "CMD_GO was written with 4 commands waiting; that command was dropped."; } ovf[1:1] = 1'b0;
  } EVENT @ 0x008;

  reg {
    name = "TIMING0";
    desc = "Bus cycle phases in clk_nand clocks (20 ns), 1 to 15; 0 counts as 1. A command takes TIMING0, TIMING1 and TIMEOUT as they are when it starts. The reset values give 100 ns cycles; 1 and 1 give 40 ns cycles, 25 MB/s.";
    field { sw = rw; hw = r; desc = "WE# low (tWP)."; } twp[3:0] = 4'd3;
    field { sw = rw; hw = r; desc = "WE# high (tWH)."; } twh[7:4] = 4'd2;
    field { sw = rw; hw = r; desc = "RE# low (tRP); DQ is sampled at the clock edge that raises RE#."; } trp[11:8] = 4'd3;
    field { sw = rw; hw = r; desc = "RE# high (tREH)."; } treh[15:12] = 4'd2;
  } TIMING0 @ 0x010;

  reg {
    name = "TIMING1";
    desc = "Waits in clk_nand clocks, 1 to 63; 0 counts as 1.";
    field { sw = rw; hw = r; desc = "From the confirm command's WE# rising to the first look at R/B# (tWB, plus 2 clocks of synchronizer)."; } twb[5:0] = 6'd12;
    field { sw = rw; hw = r; desc = "From the last WE# rising to RE# falling for a status, ID or changed-column read (tWHR)."; } twhr[13:8] = 6'd6;
    field { sw = rw; hw = r; desc = "From the last address cycle to the first data cycle of a program (tADL)."; } tadl[21:16] = 6'd10;
    field { sw = rw; hw = r; desc = "From R/B# seen ready to the first RE# falling (tRR)."; } trr[29:24] = 6'd2;
  } TIMING1 @ 0x014;

  reg {
    name = "TIMEOUT";
    field { sw = rw; hw = r; desc = "R/B# busy for more than this many units of 256 clk_nand clocks ends the command with code 2; 0 waits without limit."; } busy[15:0] = 16'd4096;
  } TIMEOUT @ 0x018;

  reg {
    name = "CMD_ROW";
    field { sw = rw; hw = r; desc = "Row address: the page in bits 5:0, the block above."; } row[23:0] = 24'h0;
  } CMD_ROW @ 0x020;

  reg {
    name = "CMD_COL";
    field { sw = rw; hw = r; desc = "Column: the byte in the page, 0 to 4319 (4096 to 4319 are the spare area). For READ_ID, the address byte."; } col[12:0] = 13'h0;
  } CMD_COL @ 0x024;

  reg {
    name = "CMD_LEN";
    field { sw = rw; hw = r; desc = "Bytes to move, 0 to 4320."; } len[12:0] = 13'h0;
  } CMD_LEN @ 0x028;

  reg {
    name = "CMD_BUF";
    field { sw = rw; hw = r; desc = "Byte offset of the data in the page buffer."; } off[12:0] = 13'h0;
  } CMD_BUF @ 0x02C;

  reg {
    name = "CMD_GO";
    desc = "A write queues a command: OP, ECC and TAG with CMD_ROW, CMD_COL, CMD_LEN and CMD_BUF as they are then.";
    field { sw = rw; hw = r; swmod; desc = "0 RESET, 1 READ_ID, 2 READ, 3 PROGRAM, 4 ERASE, 5 STATUS, 6 CHANGE READ COLUMN; 7 completes at once with no bus cycle."; } op[2:0] = 3'd0;
    field { sw = rw; hw = r; desc = "With READ or PROGRAM: the whole page through the BCH code (docs/17_bch.md). The data (4096 bytes) and metadata (32) are at CMD_BUF; CMD_COL and CMD_LEN are not used."; } ecc[3:3] = 1'b0;
    field { sw = rw; hw = r; desc = "Returned with the completion."; } tag[15:8] = 8'h0;
  } CMD_GO @ 0x030;

  reg {
    name = "CPL";
    desc = "The oldest completion; reading it removes it. VALID is 0 when none waits.";
    field { sw = r; hw = w; swacc; desc = "TAG of the command."; } tag[7:0];
    field { sw = r; hw = w; desc = "0 done, 1 status fail, 2 busy timeout, 3 write protected, 4 a codeword past correcting (CPL_ECC)."; } code[10:8];
    field { sw = r; hw = w; desc = "The status byte read after a program, an erase or STATUS; 0 otherwise."; } status[23:16];
    field { sw = r; hw = w; } valid[31:31];
  } CPL @ 0x034;

  reg {
    name = "CYCLES";
    field { sw = r; hw = w; desc = "clk_sys clocks from the dispatch of the last completed command to its completion."; } count[31:0];
  } CYCLES @ 0x038;

  reg {
    name = "BUSY_TIME";
    field { sw = r; hw = w; desc = "clk_nand clocks the last completed command waited for R/B# (saturates)."; } count[23:0];
  } BUSY_TIME @ 0x03C;

  reg {
    name = "COUNT";
    field { sw = r; hw = w; desc = "Commands completed (wraps)."; } done[15:0];
    field { sw = r; hw = w; desc = "Of them, with a code other than 0 (wraps)."; } err[31:16];
  } COUNT @ 0x040;

  reg {
    name = "CPL_ECC";
    desc = "The BCH result of the completion last read from CPL; 0 for a command without ECC.";
    field { sw = r; hw = w; desc = "Bits corrected in the page."; } bits[6:0];
    field { sw = r; hw = w; desc = "The most bits corrected in one codeword, 0 to 8."; } max[11:8];
    field { sw = r; hw = w; desc = "Codewords past correcting, one bit each; their data is as read."; } unc[23:16];
    field { sw = r; hw = w; desc = "Codewords read with at most 8 bits at 0: erased. They read as FFh, the 0 bits corrected."; } erased[31:24];
  } CPL_ECC @ 0x044;

  reg {
    name = "ECC_COUNT";
    field { sw = r; hw = w; desc = "Bits corrected (wraps)."; } bits[15:0];
    field { sw = r; hw = w; desc = "Codewords past correcting (wraps)."; } unc[31:16];
  } ECC_COUNT @ 0x048;
};

addrmap soc_apb {
  name = "APB peripherals";
  desc = "Register blocks in the APB window at 0x4000_0000, one 4 KiB slot each.";
  sys_regs   SYS   @ 0x0000;
  pmu_regs   PMU   @ 0x1000;
  intc_regs  INTC  @ 0x2000;
  timer_regs TIMER @ 0x3000;
  dma_regs   DMA   @ 0x4000;
  host_regs  HOST  @ 0x5000;
  nand_regs  NAND0 @ 0x6000;
  nand_regs  NAND1 @ 0x7000;
  nvme_regs  NVME  @ 0x8000;
};
