// Storage_SoC APB register blocks.
//
// This file is the single source for:
//   rtl/csr/gen/*.sv             register RTL         (PeakRDL-regblock, one module per block)
//   fw/common/soc_regs.h         firmware header      (PeakRDL-cheader)
//   dv/ral/soc_apb_ral_pkg.sv    UVM register model   (PeakRDL-uvm)
//   docs/regs/soc_apb.md         register document    (PeakRDL-markdown)
// flow/rdl/gen.sh regenerates all of them; the generated files are committed.
//
// Hardware behavior around the registers (counting, interrupt priority,
// console and exit events) is in rtl/periph/apb_*.sv.

addrmap sys_regs {
  name = "SYS";
  desc = "Identification, a scratch register, and the simulation console and exit registers.";
  default regwidth = 32;
  default accesswidth = 32;

  reg {
    name = "ID";
    desc = "Fixed identification value, \"SSOC\" in ASCII.";
    field { sw = r; hw = na; } value[31:0] = 32'h5353_4F43;
  } ID @ 0x000;

  reg {
    name = "VERSION";
    desc = "Register map version: 0x0001_0006 is the map of step 1-6 (DMA added).";
    field { sw = r; hw = na; } value[31:0] = 32'h0001_0006;
  } VERSION @ 0x004;

  reg {
    name = "SCRATCH";
    desc = "Free for software. Byte strobes are honored.";
    field { sw = rw; hw = na; } value[31:0] = 32'h0;
  } SCRATCH @ 0x008;

  reg {
    name = "CONSOLE";
    desc = "A write sends CHAR to the simulation console. Reads return 0.";
    field { sw = w; hw = r; swmod; } char[7:0] = 8'h0;
  } CONSOLE @ 0x010;

  reg {
    name = "EXIT";
    desc = "A write ends the simulation with CODE; 0 means pass. Reads return 0.";
    field { sw = w; hw = r; swmod; } code[31:0] = 32'h0;
  } EXIT @ 0x014;
};

addrmap intc_regs {
  name = "INTC";
  desc = "Interrupt controller for level sources 1 to 31. Source IDs are in docs/01, section 7.";
  default regwidth = 32;
  default accesswidth = 32;

  reg {
    name = "PENDING";
    desc = "Sources that are high, OR SWSET. Bit 0 is always 0.";
    field { sw = r; hw = w; } value[31:0];
  } PENDING @ 0x000;

  reg {
    name = "ENABLE";
    desc = "A source raises the core's external interrupt only while its bit is set.";
    field { sw = rw; hw = r; } value[31:0] = 32'h0;
  } ENABLE @ 0x004;

  reg {
    name = "CLAIM";
    desc = "Lowest ID that is pending and enabled, 0 if none. Reading has no side effect.";
    field { sw = r; hw = w; } id[4:0];
  } CLAIM @ 0x008;

  reg {
    name = "SWSET";
    desc = "Software-set sources, ORed into PENDING.";
    field { sw = rw; hw = r; } value[31:0] = 32'h0;
  } SWSET @ 0x00C;
};

addrmap timer_regs {
  name = "TIMER";
  desc = "RISC-V machine timer. The interrupt is high while MTIME >= MTIMECMP.";
  default regwidth = 32;
  default accesswidth = 32;

  reg {
    name = "MTIME_LO";
    desc = "mtime[31:0]. Counts while CTRL.ENABLE is set; a software write takes precedence.";
    field { sw = rw; hw = rw; we; } value[31:0] = 32'h0;
  } MTIME_LO @ 0x000;

  reg {
    name = "MTIME_HI";
    desc = "mtime[63:32].";
    field { sw = rw; hw = rw; we; } value[31:0] = 32'h0;
  } MTIME_HI @ 0x004;

  reg {
    name = "MTIMECMP_LO";
    desc = "mtimecmp[31:0].";
    field { sw = rw; hw = r; } value[31:0] = 32'hFFFF_FFFF;
  } MTIMECMP_LO @ 0x008;

  reg {
    name = "MTIMECMP_HI";
    desc = "mtimecmp[63:32]. Write 0xFFFF_FFFF here first when changing MTIMECMP.";
    field { sw = rw; hw = r; } value[31:0] = 32'hFFFF_FFFF;
  } MTIMECMP_HI @ 0x00C;

  reg {
    name = "CTRL";
    field { sw = rw; hw = r; desc = "Count enable."; } enable[0:0] = 1'b1;
    field { sw = rw; hw = r; desc = "MTIME advances every PRESCALE + 1 clocks."; } prescale[15:8] = 8'h0;
  } CTRL @ 0x010;
};

addrmap dma_regs {
  name = "DMA";
  desc = "Descriptor-based DMA (rtl/dma/dma.sv). Descriptor format and error causes are in docs/06_dma.md.";
  default regwidth = 32;
  default accesswidth = 32;

  reg {
    name = "CTRL";
    desc = "Write 1 to START to run the chain at DESC_PTR, or to ABORT to stop a running chain. Both read as 0. START while BUSY is ignored.";
    field { sw = w; hw = r; singlepulse; desc = "Start the chain at DESC_PTR."; } start[0:0] = 1'b0;
    field { sw = w; hw = r; singlepulse; desc = "Stop after the transactions already issued complete."; } abort[1:1] = 1'b0;
  } CTRL @ 0x000;

  reg {
    name = "DESC_PTR";
    desc = "Address of the first descriptor; 16-byte aligned.";
    field { sw = rw; hw = r; } addr[31:0] = 32'h0;
  } DESC_PTR @ 0x004;

  reg {
    name = "STATUS";
    desc = "DONE and ERR are the DMA's two interrupt sources (INTC 1 and 2). Write 1 to clear; START clears both. A hardware set wins over a software clear in the same clock, so no event is lost.";
    field { sw = r; hw = w; desc = "A chain is running."; } busy[0:0];
    field { sw = rw; onwrite = woclr; hw = r; hwset; hwclr; precedence = hw; desc = "The chain completed."; } done[1:1] = 1'b0;
    field { sw = rw; onwrite = woclr; hw = r; hwset; hwclr; precedence = hw; desc = "The chain stopped on an error or an abort; see ERR_INFO."; } err[2:2] = 1'b0;
  } STATUS @ 0x008;

  reg {
    name = "ERR_INFO";
    desc = "Why the last run stopped. Cleared by START.";
    field { sw = r; hw = w; we; desc = "1 descriptor read error, 2 data read error, 3 data write error, 4 bad descriptor or DESC_PTR, 5 aborted."; } cause[2:0] = 3'h0;
    field { sw = r; hw = w; we; desc = "RRESP or BRESP of the failed transaction (causes 1 to 3)."; } resp[5:4] = 2'h0;
  } ERR_INFO @ 0x00C;

  reg {
    name = "ERR_ADDR";
    desc = "Causes 1 and 4: the descriptor's address. Causes 2 and 3: the start address of the failed burst. Cause 5: CUR_DESC.";
    field { sw = r; hw = w; we; } addr[31:0] = 32'h0;
  } ERR_ADDR @ 0x010;

  reg {
    name = "CUR_DESC";
    desc = "Address of the descriptor whose data is being read, or was read last.";
    field { sw = r; hw = w; } addr[31:0];
  } CUR_DESC @ 0x014;

  reg {
    name = "DESC_DONE";
    desc = "Descriptors whose writes all completed in this run, counted until the first error.";
    field { sw = r; hw = w; } count[15:0];
  } DESC_DONE @ 0x018;

  reg {
    name = "CYCLES";
    desc = "Clocks from START to the end of the run (counting while BUSY).";
    field { sw = r; hw = w; } count[31:0];
  } CYCLES @ 0x01C;
};

addrmap soc_apb {
  name = "APB peripherals";
  desc = "Register blocks in the APB window at 0x4000_0000, one 4 KiB slot each.";
  sys_regs   SYS   @ 0x0000;
  intc_regs  INTC  @ 0x2000;
  timer_regs TIMER @ 0x3000;
  dma_regs   DMA   @ 0x4000;
};
