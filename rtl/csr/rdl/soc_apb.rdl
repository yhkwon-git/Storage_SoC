// Storage_SoC APB register blocks.
//
// This file is the single source for:
//   rtl/csr/gen/*.sv             register RTL         (PeakRDL-regblock, one module per block)
//   fw/common/soc_regs.h         firmware header      (PeakRDL-cheader)
//   dv/ral/soc_apb_ral_pkg.sv    UVM register model   (PeakRDL-uvm)
//   docs/regs/soc_apb.md         register document    (PeakRDL-markdown)
// flow/rdl/gen.sh regenerates all of them; the generated files are committed.
//
// Hardware behavior around the registers (counting, interrupt priority,
// console and exit events) is in rtl/periph/apb_*.sv.

addrmap sys_regs {
  name = "SYS";
  desc = "Identification, a scratch register, and the simulation console and exit registers.";
  default regwidth = 32;
  default accesswidth = 32;

  reg {
    name = "ID";
    desc = "Fixed identification value, \"SSOC\" in ASCII.";
    field { sw = r; hw = na; } value[31:0] = 32'h5353_4F43;
  } ID @ 0x000;

  reg {
    name = "VERSION";
    desc = "Register map version: 0x0001_0007 is the map of step 1-7 (PMU, HOST placeholder, SYS control registers added).";
    field { sw = r; hw = na; } value[31:0] = 32'h0001_0007;
  } VERSION @ 0x004;

  reg {
    name = "SCRATCH";
    desc = "Free for software. Byte strobes are honored.";
    field { sw = rw; hw = na; } value[31:0] = 32'h0;
  } SCRATCH @ 0x008;

  reg {
    name = "CONSOLE";
    desc = "A write sends CHAR to the simulation console. Reads return 0.";
    field { sw = w; hw = r; swmod; } char[7:0] = 8'h0;
  } CONSOLE @ 0x010;

  reg {
    name = "EXIT";
    desc = "A write ends the simulation with CODE; 0 means pass. Reads return 0.";
    field { sw = w; hw = r; swmod; } code[31:0] = 32'h0;
  } EXIT @ 0x014;

  // Control registers start at 0x100; 0x018 to 0x0FC stay undefined.
  reg {
    name = "SOFT_RESET";
    desc = "While a bit is 1 its block is held in reset. Use only while the block is idle: a block reset with transactions outstanding leaves them unanswered.";
    field { sw = rw; hw = r; desc = "DMA, registers included."; } dma[0:0] = 1'b0;
  } SOFT_RESET @ 0x100;

  reg {
    name = "CLK_GATE";
    desc = "Clock gates for idle blocks.";
    field { sw = rw; hw = r; desc = "Gate the CPU's clock while it sleeps in WFI with no interrupt pending, as Ibex's own top level does."; } cpu[0:0] = 1'b1;
  } CLK_GATE @ 0x104;

  reg {
    name = "SLEEP_CYCLES";
    desc = "Clocks the CPU's clock gate has removed since reset.";
    field { sw = r; hw = w; } count[31:0];
  } SLEEP_CYCLES @ 0x108;
};

addrmap pmu_regs {
  name = "PMU";
  desc = "Power management in PD_AON, clocked by clk_aon and reset only at power-on; reached through an APB clock-domain crossing (rtl/pmu/apb_cdc.sv), so an access takes a few clk_aon cycles. Sequences and states are in docs/07_clock_reset_power.md.";
  default regwidth = 32;
  default accesswidth = 32;

  reg {
    name = "PWR_CTRL";
    desc = "UP starts the PD_HOST power-up sequence from OFF or FAIL; DOWN starts the power-down sequence from ON. Both read as 0.";
    field { sw = w; hw = r; singlepulse; } up[0:0] = 1'b0;
    field { sw = w; hw = r; singlepulse; } down[1:1] = 1'b0;
    field { sw = rw; hw = r; desc = "A rising edge on the wake pin powers PD_HOST up from OFF."; } wake_en[8:8] = 1'b1;
  } PWR_CTRL @ 0x000;

  reg {
    name = "PWR_STATUS";
    field { sw = r; hw = w; desc = "Sequencer state: 0 OFF, 1-4 powering up, 5 ON, 6-10 powering down, 11 FAIL."; } state[3:0];
    field { sw = r; hw = w; desc = "PD_HOST is on with isolation released."; } on[8:8];
    field { sw = r; hw = w; desc = "Last sequence: 0 none, 1 completed, 2 power-down refused (host path busy), 3 timeout."; } result[17:16];
    field { sw = r; hw = w; desc = "The last power-up was started by the wake pin."; } woke[24:24];
  } PWR_STATUS @ 0x004;

  reg {
    name = "PWR_IRQ";
    desc = "INTC source 10. Write 1 to clear. A hardware set wins over a software clear in the same clock.";
    field { sw = rw; onwrite = woclr; hw = r; hwset; precedence = hw; desc = "A sequence completed."; } done[0:0] = 1'b0;
    field { sw = rw; onwrite = woclr; hw = r; hwset; precedence = hw; desc = "A power-down was refused or a sequence timed out."; } err[1:1] = 1'b0;
  } PWR_IRQ @ 0x008;

  reg {
    name = "TIMEOUT";
    desc = "clk_aon cycles each wait of a sequence may take (switch acknowledge, PLL lock).";
    field { sw = rw; hw = r; } cycles[15:0] = 16'd64;
  } TIMEOUT @ 0x00C;

  reg {
    name = "CHIP_RESET";
    desc = "Writing 0x5AFE_0001 resets PD_CORE and PD_HOST's logic and runs the reset release order again; PD_AON and PD_HOST's power state are kept. Any other value is ignored. Reads return 0.";
    field { sw = w; hw = r; swmod; } key[31:0] = 32'h0;
  } CHIP_RESET @ 0x010;

  reg {
    name = "RST_CAUSE";
    desc = "Why PD_CORE was last reset. Write 1 to clear.";
    field { sw = rw; onwrite = woclr; hw = r; hwset; precedence = hw; desc = "Power-on reset."; } por[0:0] = 1'b0;
    field { sw = rw; onwrite = woclr; hw = r; hwset; precedence = hw; desc = "CHIP_RESET."; } chip[1:1] = 1'b0;
  } RST_CAUSE @ 0x014;

  reg {
    name = "AON_SCRATCH";
    desc = "Free for software; kept across a chip reset.";
    field { sw = rw; hw = na; } value[31:0] = 32'h0;
  } AON_SCRATCH @ 0x018;

  reg {
    name = "PWR_CYCLES";
    desc = "Completed PD_HOST power-downs since power-on.";
    field { sw = r; hw = w; } count[15:0];
  } PWR_CYCLES @ 0x01C;
};

addrmap host_regs {
  name = "HOST";
  desc = "Core side of the PD_HOST placeholder (rtl/host/): a command FIFO into PD_HOST and a response FIFO out of it. Phase 2 replaces this block with the host interface's registers.";
  default regwidth = 32;
  default accesswidth = 32;

  reg {
    name = "TX";
    desc = "A write sends one command into PD_HOST. It is dropped, and STATUS.TX_DROP set, when the FIFO is full or PD_HOST is not on.";
    field { sw = w; hw = r; swmod; } data[31:0] = 32'h0;
  } TX @ 0x000;

  reg {
    name = "RX";
    desc = "Oldest response; reading it removes it. Reads 0 when STATUS.RX_VALID is 0.";
    field { sw = r; hw = w; swacc; } data[31:0];
  } RX @ 0x004;

  reg {
    name = "STATUS";
    field { sw = r; hw = w; desc = "A response is waiting in RX."; } rx_valid[0:0];
    field { sw = r; hw = w; desc = "The command FIFO is full."; } tx_full[1:1];
    field { sw = r; hw = w; desc = "PD_HOST is on (PMU)."; } on[2:2];
    field { sw = r; hw = w; desc = "Every command sent has had its response read: the host path is idle."; } idle[3:3];
    field { sw = rw; onwrite = woclr; hw = r; hwset; precedence = hw; desc = "A command was dropped."; } tx_drop[8:8] = 1'b0;
  } STATUS @ 0x008;
};

addrmap intc_regs {
  name = "INTC";
  desc = "Interrupt controller for level sources 1 to 31. Source IDs are in docs/01, section 7.";
  default regwidth = 32;
  default accesswidth = 32;

  reg {
    name = "PENDING";
    desc = "Sources that are high, OR SWSET. Bit 0 is always 0.";
    field { sw = r; hw = w; } value[31:0];
  } PENDING @ 0x000;

  reg {
    name = "ENABLE";
    desc = "A source raises the core's external interrupt only while its bit is set.";
    field { sw = rw; hw = r; } value[31:0] = 32'h0;
  } ENABLE @ 0x004;

  reg {
    name = "CLAIM";
    desc = "Lowest ID that is pending and enabled, 0 if none. Reading has no side effect.";
    field { sw = r; hw = w; } id[4:0];
  } CLAIM @ 0x008;

  reg {
    name = "SWSET";
    desc = "Software-set sources, ORed into PENDING.";
    field { sw = rw; hw = r; } value[31:0] = 32'h0;
  } SWSET @ 0x00C;
};

addrmap timer_regs {
  name = "TIMER";
  desc = "RISC-V machine timer. The interrupt is high while MTIME >= MTIMECMP.";
  default regwidth = 32;
  default accesswidth = 32;

  reg {
    name = "MTIME_LO";
    desc = "mtime[31:0]. Counts while CTRL.ENABLE is set; a software write takes precedence.";
    field { sw = rw; hw = rw; we; } value[31:0] = 32'h0;
  } MTIME_LO @ 0x000;

  reg {
    name = "MTIME_HI";
    desc = "mtime[63:32].";
    field { sw = rw; hw = rw; we; } value[31:0] = 32'h0;
  } MTIME_HI @ 0x004;

  reg {
    name = "MTIMECMP_LO";
    desc = "mtimecmp[31:0].";
    field { sw = rw; hw = r; } value[31:0] = 32'hFFFF_FFFF;
  } MTIMECMP_LO @ 0x008;

  reg {
    name = "MTIMECMP_HI";
    desc = "mtimecmp[63:32]. Write 0xFFFF_FFFF here first when changing MTIMECMP.";
    field { sw = rw; hw = r; } value[31:0] = 32'hFFFF_FFFF;
  } MTIMECMP_HI @ 0x00C;

  reg {
    name = "CTRL";
    field { sw = rw; hw = r; desc = "Count enable."; } enable[0:0] = 1'b1;
    field { sw = rw; hw = r; desc = "MTIME advances every PRESCALE + 1 clocks."; } prescale[15:8] = 8'h0;
  } CTRL @ 0x010;
};

addrmap dma_regs {
  name = "DMA";
  desc = "Descriptor-based DMA (rtl/dma/dma.sv). Descriptor format and error causes are in docs/06_dma.md.";
  default regwidth = 32;
  default accesswidth = 32;

  reg {
    name = "CTRL";
    desc = "Write 1 to START to run the chain at DESC_PTR, or to ABORT to stop a running chain. Both read as 0. START while BUSY is ignored.";
    field { sw = w; hw = r; singlepulse; desc = "Start the chain at DESC_PTR."; } start[0:0] = 1'b0;
    field { sw = w; hw = r; singlepulse; desc = "Stop after the transactions already issued complete."; } abort[1:1] = 1'b0;
  } CTRL @ 0x000;

  reg {
    name = "DESC_PTR";
    desc = "Address of the first descriptor; 16-byte aligned.";
    field { sw = rw; hw = r; } addr[31:0] = 32'h0;
  } DESC_PTR @ 0x004;

  reg {
    name = "STATUS";
    desc = "DONE and ERR are the DMA's two interrupt sources (INTC 1 and 2). Write 1 to clear; START clears both. A hardware set wins over a software clear in the same clock, so no event is lost.";
    field { sw = r; hw = w; desc = "A chain is running."; } busy[0:0];
    field { sw = rw; onwrite = woclr; hw = r; hwset; hwclr; precedence = hw; desc = "The chain completed."; } done[1:1] = 1'b0;
    field { sw = rw; onwrite = woclr; hw = r; hwset; hwclr; precedence = hw; desc = "The chain stopped on an error or an abort; see ERR_INFO."; } err[2:2] = 1'b0;
  } STATUS @ 0x008;

  reg {
    name = "ERR_INFO";
    desc = "Why the last run stopped. Cleared by START.";
    field { sw = r; hw = w; we; desc = "1 descriptor read error, 2 data read error, 3 data write error, 4 bad descriptor or DESC_PTR, 5 aborted."; } cause[2:0] = 3'h0;
    field { sw = r; hw = w; we; desc = "RRESP or BRESP of the failed transaction (causes 1 to 3)."; } resp[5:4] = 2'h0;
  } ERR_INFO @ 0x00C;

  reg {
    name = "ERR_ADDR";
    desc = "Causes 1 and 4: the descriptor's address. Causes 2 and 3: the start address of the failed burst. Cause 5: CUR_DESC.";
    field { sw = r; hw = w; we; } addr[31:0] = 32'h0;
  } ERR_ADDR @ 0x010;

  reg {
    name = "CUR_DESC";
    desc = "Address of the descriptor whose data is being read, or was read last.";
    field { sw = r; hw = w; } addr[31:0];
  } CUR_DESC @ 0x014;

  reg {
    name = "DESC_DONE";
    desc = "Descriptors whose writes all completed in this run, counted until the first error.";
    field { sw = r; hw = w; } count[15:0];
  } DESC_DONE @ 0x018;

  reg {
    name = "CYCLES";
    desc = "Clocks from START to the end of the run (counting while BUSY).";
    field { sw = r; hw = w; } count[31:0];
  } CYCLES @ 0x01C;
};

addrmap soc_apb {
  name = "APB peripherals";
  desc = "Register blocks in the APB window at 0x4000_0000, one 4 KiB slot each.";
  sys_regs   SYS   @ 0x0000;
  pmu_regs   PMU   @ 0x1000;
  intc_regs  INTC  @ 0x2000;
  timer_regs TIMER @ 0x3000;
  dma_regs   DMA   @ 0x4000;
  host_regs  HOST  @ 0x5000;
};
